* NGSPICE file created from opamp.ext - technology: sky130A

.subckt opamp VINP VSS
X0 VSUBS a_8186_n6# sky130_fd_pr__diode_pw2nd_05v5 perim=3.8e+06 area=8.944e+11
X1 VSUBS a_7046_n18# sky130_fd_pr__diode_pw2nd_05v5 perim=4.1e+06 area=1.02e+12
X2 a_3566_104# a_3720_154# a_3566_104# VSUBS sky130_fd_pr__nfet_01v8 ad=1.0395 pd=3.21 as=0 ps=0 w=3.64 l=13.82
X3 VSUBS a_6484_154# sky130_fd_pr__diode_pw2nd_05v5 perim=8.86e+06 area=2.8756e+12
X4 c1_5200_1400# m3_5172_1372# sky130_fd_pr__cap_mim_m3_1 l=2.8 w=2.8
X5 VSUBS a_n854_n56# sky130_fd_pr__diode_pw2nd_05v5_nvt perim=7.22e+06 area=3.2028e+12
C0 VSS w_7000_1200# 0
C1 m1_400_1000# m1_124_2004# 1.22703f
C2 m1_400_1000# VINP 0.16005f
C3 VSS m1_3600_140# 0.58893f
C4 a_7010_1302# m1_5200_1400# 0.00226f
C5 VSS w_3500_1200# 0
C6 a_3720_154# m1_3600_140# 2.25416f
C7 a_6484_154# VSS 0.00328f
C8 m1_3600_140# a_7216_n52# 0
C9 a_7010_1302# m1_7100_160# 0.23418f
C10 VSS m2_5200_1400# 0
C11 a_3482_1286# m1_5200_1400# 0.01799f
C12 a_7046_n18# m1_7100_160# 0.01578f
C13 m3_5172_1372# a_7010_1302# 0.00645f
C14 a_7010_1302# w_7000_1200# 0.80453f
C15 a_304_1288# m1_124_2004# 0.1897f
C16 m1_124_2004# m1_5200_1400# 0.27378f
C17 VSS li_120_n40# 0.10659f
C18 a_7010_1302# w_3500_1200# 0.00154f
C19 m3_5172_1372# a_3482_1286# 0.03001f
C20 m1_124_2004# w_300_1200# 0.06763f
C21 m1_3600_140# a_7046_n18# 0
C22 a_7010_1302# m2_5200_1400# 0.00171f
C23 VSS a_7216_n52# 0.01211f
C24 m1_3600_140# a_3482_1286# 0.04483f
C25 a_3482_1286# w_3500_1200# 1.06943f
C26 m3_5172_1372# m1_124_2004# 0.04499f
C27 m1_7100_1440# m1_5200_1400# 0.01646f
C28 m1_124_2004# w_7000_1200# 0.06177f
C29 m1_124_2004# m1_3600_140# 0.05127f
C30 a_3482_1286# m2_5200_1400# 0.01062f
C31 m1_7100_1440# m1_7100_160# 0.40615f
C32 VINP m1_3600_140# 0.03043f
C33 m1_124_2004# w_3500_1200# 0.20645f
C34 m1_400_1000# a_304_1288# 0.92113f
C35 a_7010_1302# VSS 0
C36 a_8186_n6# m1_7100_160# 0.01309f
C37 m1_124_2004# a_6484_154# 0
C38 m1_400_1000# m1_5200_1400# 0.04313f
C39 m3_5172_1372# m1_7100_1440# 0.00366f
C40 m1_124_2004# m2_5200_1400# 0.0704f
C41 m1_7100_1440# w_7000_1200# 0.00392f
C42 VSS a_7046_n18# 0.01073f
C43 m1_400_1000# w_300_1200# 0.05689f
C44 VSS a_3482_1286# 0
C45 w_3500_1200# m1_7100_1440# 0
C46 m1_3600_140# a_8186_n6# 0
C47 m1_400_1000# m3_5172_1372# 0.0352f
C48 VSS a_n700_n100# 0.00419f
C49 a_n700_258# VSS 0.00189f
C50 VINP li_120_n40# 0.02642f
C51 m1_7100_1440# m2_5200_1400# 0.001f
C52 m1_400_1000# m1_3600_140# 0.10181f
C53 VSS VINP 2.92432f
C54 m1_400_1000# w_3500_1200# 0.06854f
C55 a_n854_n56# li_120_n40# 0.00496f
C56 a_304_1288# w_300_1200# 0.84646f
C57 m1_400_1000# m2_5200_1400# 0.01146f
C58 VSS a_n854_n56# 0.09429f
C59 VSS a_8186_n6# 0
C60 m3_5172_1372# m1_5200_1400# 0.01834f
C61 w_7000_1200# m1_5200_1400# 0
C62 m1_124_2004# a_7010_1302# 0.214f
C63 m1_3600_140# m1_5200_1400# 0.0448f
C64 m1_400_1000# VSS 0.26274f
C65 w_7000_1200# m1_7100_160# 0.08584f
C66 w_3500_1200# m1_5200_1400# 0.13415f
C67 m1_124_2004# a_3482_1286# 0.24111f
C68 m1_3600_140# m1_7100_160# 0.0592f
C69 m3_5172_1372# w_7000_1200# 0
C70 m1_5200_1400# m2_5200_1400# 1.04946f
C71 a_7010_1302# m1_7100_1440# 0.8502f
C72 a_6484_154# m1_7100_160# 0.0039f
C73 m3_5172_1372# m1_3600_140# 0.03691f
C74 m3_5172_1372# w_3500_1200# 0.0436f
C75 m1_124_2004# VINP 0.00195f
C76 m1_3600_140# w_3500_1200# 0.02502f
C77 a_304_1288# VSS 0.03957f
C78 m3_5172_1372# m2_5200_1400# 0.75074f
C79 w_7000_1200# m2_5200_1400# 0
C80 a_6484_154# m1_3600_140# 0.08494f
C81 m1_3600_140# m2_5200_1400# 0.01065f
C82 m1_124_2004# m1_7100_1440# 0.58667f
C83 w_300_1200# VSS 0.0191f
C84 VSS m1_7100_160# 0.0046f
C85 w_3500_1200# m2_5200_1400# 0.04349f
C86 m1_400_1000# a_3482_1286# 0.93875f
C87 a_7216_n52# m1_7100_160# 0.1557f
C88 m3_5172_1372# VSS 0.0013f
C89 VSS VSUBS 3.16952f
C90 m3_5172_1372# VSUBS 0.44886f
C91 m2_5200_1400# VSUBS 0.28971f $ **FLOATING
C92 m1_7100_160# VSUBS 1.31351f $ **FLOATING
C93 m1_3600_140# VSUBS 0.67027f $ **FLOATING
C94 m1_7100_1440# VSUBS 0.15746f $ **FLOATING
C95 m1_5200_1400# VSUBS 0.29135f $ **FLOATING
C96 m1_400_1000# VSUBS 1.05003f $ **FLOATING
C97 m1_124_2004# VSUBS 2.26799f $ **FLOATING
C98 li_120_n40# VSUBS 0.10262f $ **FLOATING
C99 a_7010_1302# VSUBS 0.74961f $ **FLOATING
C100 a_3482_1286# VSUBS 0.77897f $ **FLOATING
C101 a_304_1288# VSUBS 0.73452f $ **FLOATING
C102 w_7000_1200# VSUBS 4.2f $ **FLOATING
C103 w_300_1200# VSUBS 3.9f $ **FLOATING
C104 w_3500_1200# VSUBS 5.63466f $ **FLOATING
.ends
